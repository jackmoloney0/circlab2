* op_peak_min -- generated by tools/run_sims.py (ngspice)
.include ../ltspice/uA741.lib
.options savecurrents
VCC vcc 0 DC 5.0
VEE vee 0 DC -5.0
VIN in 0 DC 0.5
R3 in 0 10000.0
R1 out inv 0.001
R2 inv 0 10000.0
XU1 in inv vcc vee oa uA741
VIOUT oa out DC 0
.control
op
let q0 = v(in)
echo "q0 = $&q0"
let q1 = v(inv)
echo "q1 = $&q1"
let q2 = v(out)
echo "q2 = $&q2"
let q3 = @r1[i]
echo "q3 = $&q3"
let q4 = @r2[i]
echo "q4 = $&q4"
let q5 = @r3[i]
echo "q5 = $&q5"
let q6 = i(viout)
echo "q6 = $&q6"
let q7 = i(vcc)
echo "q7 = $&q7"
let q8 = i(vee)
echo "q8 = $&q8"
.endc
.end
