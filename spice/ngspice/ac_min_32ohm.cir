* ac_min_32ohm -- generated by tools/run_sims.py (ngspice)
.include ../ltspice/uA741.lib
.options savecurrents
VCC vcc 0 DC 5.0
VEE vee 0 DC -5.0
VIN in 0 DC 0 AC 1
R3 in 0 10000.0
R1 out inv 0.001
R2 inv 0 10000.0
XU1 in inv vcc vee oa uA741
VIOUT oa out DC 0
RL out 0 32
.control
ac dec 200 1 10meg
let g = vm(out)/vm(in)
let ph = 180/pi*cph(v(out))
meas ac g1k find g at=1k
meas ac ph1k find ph at=1k
meas ac g20k find g at=20k
meas ac g10 find g at=10
let g3 = g10/sqrt(2)
meas ac f3db when g=g3 fall=1
set wr_singlescale
set wr_vecnames
wrdata ../../spice/results/ac_min_32ohm.csv g ph
.endc
.end
