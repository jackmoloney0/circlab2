* tran100mvpp_min -- generated by tools/run_sims.py (ngspice)
.include ../ltspice/uA741.lib
.options savecurrents
VCC vcc 0 DC 5.0
VEE vee 0 DC -5.0
VIN in 0 DC 0 SIN(0 0.05 1000.0)
R3 in 0 10000.0
R1 out inv 0.001
R2 inv 0 10000.0
XU1 in inv vcc vee oa uA741
VIOUT oa out DC 0
.control
tran 2.5u 0.006 0 0.5u
meas tran vinpp pp v(in) from=0.002 to=0.006
meas tran voutpp pp v(out) from=0.002 to=0.006
meas tran vinrms rms v(in) from=0.002 to=0.006
meas tran voutrms rms v(out) from=0.002 to=0.006
meas tran voutmax max v(out) from=0.002 to=0.006
meas tran voutmin min v(out) from=0.002 to=0.006
meas tran ioutmax max i(viout) from=0.002 to=0.006
meas tran pk0 find v(in) at=0.00425
meas tran pk1 find v(inv) at=0.00425
meas tran pk2 find v(out) at=0.00425
meas tran pk3 find @r1[i] at=0.00425
meas tran pk4 find @r2[i] at=0.00425
meas tran pk5 find @r3[i] at=0.00425
meas tran pk6 find i(viout) at=0.00425
meas tran pk7 find i(vcc) at=0.00425
meas tran pk8 find i(vee) at=0.00425
meas tran nk0 find v(in) at=0.00475
meas tran nk1 find v(inv) at=0.00475
meas tran nk2 find v(out) at=0.00475
meas tran nk3 find @r1[i] at=0.00475
meas tran nk4 find @r2[i] at=0.00475
meas tran nk5 find @r3[i] at=0.00475
meas tran nk6 find i(viout) at=0.00475
meas tran nk7 find i(vcc) at=0.00475
meas tran nk8 find i(vee) at=0.00475
set wr_singlescale
set wr_vecnames
linearize v(in) v(inv) v(out) @r1[i] @r2[i] @r3[i] i(viout)
wrdata ../../spice/results/tran100mvpp_min.csv v(in) v(inv) v(out) @r1[i] @r2[i] @r3[i] i(viout)
.endc
.end
